* p5_2_5 exact   Re=2.6733 k  Rb1=86 k  Rb2=37.7778 k
* beta=100, VAF=0 (no Early effect), IS tuned so that VBE=0.700 V at IC=1 mA
VCC 1 0 12
Rb1 1 2 86k
Rb2 2 0 37.7777777778k
Rc  1 3 4.3k
Re  4 0 2.67326732673k
Q1  3 2 4 QNPN
.model QNPN NPN (IS=1.7635767730136541e-15 BF=100 VAF=0 RB=0 RC=0 RE=0)
.control
set numdgt=12
op
print @q1[ic] @q1[ib] @q1[vbe]
print @rb1[i] @rb2[i] @rc[i] @re[i]
print v(1) v(2) v(3) v(4)
let vce = v(3)-v(4)
let ratio = @rb1[i]/@q1[ib]
print vce ratio
.endc
.end
