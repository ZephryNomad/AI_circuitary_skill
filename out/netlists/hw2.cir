* 习题2 电桥（端口在中间节点）
* 由 circuitary/tools/netlist.py 生成；元件语义与 SPICE3 一致
* 参考节点(地) = 0
* 节点清单: 1, 0, 2, 3
* 戴维宁端口: a=2  b=3（开路电压 u_oc = V(a)-V(b)）
*
VUs    1    0    12
R1     1    2    2
R2     2    0    4
R3     1    3    8
R4     3    0    4
.op
.end
