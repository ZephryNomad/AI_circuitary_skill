* 例3 不平衡电桥
* 由 circuitary/tools/netlist.py 生成；元件语义与 SPICE3 一致
* 参考节点(地) = 0
* 节点清单: 1, 0, 2, 3
* 戴维宁端口: a=2  b=3（开路电压 u_oc = V(a)-V(b)）
*
VUs    1    0    12
R1     1    2    1
R2     2    0    3
R3     1    3    9
R4     3    0    3
.op
.end
