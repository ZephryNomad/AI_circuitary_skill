* 习题 2-3 电源等效变换求支路电流 I
* 由 circuitary/tools/netlist.py 生成；元件语义与 SPICE3 一致
* 参考节点(地) = 0
* 节点清单: 1, 0, 2, 3, 4, 5
*
VUs    1    0    8
R1     1    2    4
R2     2    0    4
R3     2    3    1
R4     3    4    2
VU2    4    0    10
R5     3    5    2
Is     0    5    2
.op
.end
