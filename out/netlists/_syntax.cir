* 语法自测（求: 的四种写法）
* 由 circuitary/tools/netlist.py 生成；元件语义与 SPICE3 一致
* 参考节点(地) = 0
* 节点清单: 1, 0, 2
*
VUs    1    0    12
R1     1    2    2
R2     2    0    4
.op
.end
