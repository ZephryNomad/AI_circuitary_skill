* 例5 含 VCCS 与负号的含义
* 由 circuitary/tools/netlist.py 生成；元件语义与 SPICE3 一致
* 参考节点(地) = 0
* 节点清单: 1, 0, 2, 3
* 戴维宁端口: a=3  b=0（开路电压 u_oc = V(a)-V(b)）
*
VUs    1    0    12
R1     1    2    2
R2     2    0    2
R3     2    3    3
G1     3    0    2    0    1
.op
.end
