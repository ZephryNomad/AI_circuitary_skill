* 例2 电流源激励
* 由 circuitary/tools/netlist.py 生成；元件语义与 SPICE3 一致
* 参考节点(地) = 0
* 节点清单: 0, 1, 2
* 戴维宁端口: a=2  b=0（开路电压 u_oc = V(a)-V(b)）
*
Is     0    1    2
R1     1    0    3
R2     1    2    3
R3     2    0    12
.op
.end
