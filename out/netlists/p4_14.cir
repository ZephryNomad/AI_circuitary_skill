* 习题 4-14 戴维宁定理求最大功率
* 由 circuitary/tools/netlist.py 生成；元件语义与 SPICE3 一致
* 参考节点(地) = 0
* 节点清单: 0, 1, 2, 3, 5, 4
* 戴维宁端口: a=4  b=0（开路电压 u_oc = V(a)-V(b)）
*
Is     0    1    6
R4     1    2    4
V16    2    0    16
R6     3    5    6
VI1    5    0    0
H1     3    1    VI1  2
V6     4    3    6
.op
.end
