* 例4 含 VCVS 的受控源网络
* 由 circuitary/tools/netlist.py 生成；元件语义与 SPICE3 一致
* 参考节点(地) = 0
* 节点清单: 1, 0, 2, 3, 4
* 戴维宁端口: a=3  b=0（开路电压 u_oc = V(a)-V(b)）
*
VUs    1    0    12
R1     1    2    2
R2     2    0    2
R3     2    3    1
R4     3    4    6
E1     4    0    2    0    2
.op
.end
