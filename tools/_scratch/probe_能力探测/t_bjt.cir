* BJT bias point
Vcc 1 0 12
Rb1 1 2 47k
Rb2 2 0 10k
Rc 1 3 2.2k
Re 4 0 470
Q1 3 2 4 QMOD
.model QMOD NPN(BF=200 IS=1e-14)
.control
op
print v(2) v(3) v(4) @q1[ic] @q1[vbe]
.endc
.end
