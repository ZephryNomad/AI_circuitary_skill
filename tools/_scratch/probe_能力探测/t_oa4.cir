* diff amp: Vout = V2 - V1 (all R = 10k)
V1 1 0 DC 3
V2 2 0 DC 5
R1 1 3 10k
R2 3 4 10k
R3 2 5 10k
R4 5 0 10k
E1 4 0 5 3 1000000
.control
op
print v(4)
.endc
.end
