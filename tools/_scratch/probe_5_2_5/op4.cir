* 5.2.5 cross-check: VAF=0 (no Early effect), BF=100 exact
VCC 1 0 12
Rb1 1 2 86k
Rb2 2 0 37.7777777777778k
Rc  1 3 4.3k
Re  4 0 2.67326732673267k
Q1  3 2 4 QNPN
.model QNPN NPN (IS=1.7635767730105438e-15 BF=100 VAF=0 RB=0 RC=0 RE=0)
.control
set numdgt=12
op
print @q1[ic] @q1[ib] @q1[vbe]
print v(2) v(3) v(4)
let vce = v(3)-v(4)
print vce
.endc
.end
