* p5_2_5 nominal design: Re=2.7k, Rb1=86k, Rb2=37.8k
VCC 1 0 12
Rb1 1 2 86k
Rb2 2 0 37.8k
Rc  1 3 4.3k
Re  4 0 2.7k
Q1  3 2 4 QNPN
.model QNPN NPN (IS=1.7635767730105438e-15 BF=100 VAF=0 RB=0 RC=0 RE=0)
.control
set numdgt=12
op
print @q1[ic] @q1[ib] @q1[vbe]
print @rb1[i] @rb2[i] @rc[i] @re[i]
print v(1) v(2) v(3) v(4)
let vce = v(3)-v(4)
let ratio_i1_ib = @rb1[i]/@q1[ib]
print vce ratio_i1_ib
.endc
.end
